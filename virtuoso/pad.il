procedure(placePadFrame( @optional no_pads )
(if (null no_pads) then
(setq no_pads (enterNumber ?prompts '("Please enter the number of pads on a side"))))

(setq xpointh 291)
(setq ypointh 201)
(setq xpointv 201)
(setq ypointv 291)

(dbCreateInst (getEditRep) (dbOpenCellViewByType "pads_ami06" "PadIO" "layout") nil (list xpointh ypointh) "R180")
(dbCreateInst (getEditRep) (dbOpenCellViewByType "pads_ami06" "PadIO"  "layout") nil (list xpointh+90 ypointh) "R180")
(dbCreateInst (getEditRep) (dbOpenCellViewByType "pads_ami06" "PadVdd" "layout") nil (list xpointh+2*90 ypointh) "R180")
(dbCreateInst (getEditRep) (dbOpenCellViewByType "pads_ami06" "PadIO"  "layout") nil (list xpointh+3*90 ypointh) "R180")
(dbCreateInst (getEditRep) (dbOpenCellViewByType "pads_ami06" "PadIO"  "layout") nil (list xpointh+4*90 ypointh) "R180")
(dbCreateInst (getEditRep) (dbOpenCellViewByType "pads_ami06" "PadIO"  "layout") nil (list xpointh+5*90 ypointh) "R180")
(dbCreateInst (getEditRep) (dbOpenCellViewByType "pads_ami06" "PadIO"  "layout") nil (list xpointh+6*90 ypointh) "R180")
(dbCreateInst (getEditRep) (dbOpenCellViewByType "pads_ami06" "PadIO"  "layout") nil (list xpointh+7*90 ypointh) "R180")
(dbCreateInst (getEditRep) (dbOpenCellViewByType "pads_ami06" "PadIO"  "layout") nil (list xpointh+8*90 ypointh) "R180")
(dbCreateInst (getEditRep) (dbOpenCellViewByType "pads_ami06" "PadIO"  "layout") nil (list xpointh+9*90 ypointh) "R180")
(dbCreateInst (getEditRep) (dbOpenCellViewByType "pads_ami06" "PadIO"  "layout") nil (list xpointh+10*90 ypointh) "R180")
(dbCreateInst (getEditRep) (dbOpenCellViewByType "pads_ami06" "PadIO"  "layout") nil (list xpointh+11*90 ypointh) "R180")

(dbCreateInst (getEditRep) (dbOpenCellViewByType "pads_ami06" "PadOut" "layout") nil (list xpointv ypointh) "R90")
(dbCreateInst (getEditRep) (dbOpenCellViewByType "pads_ami06" "PadIO"  "layout") nil (list xpointv ypointh+90) "R90")
(dbCreateInst (getEditRep) (dbOpenCellViewByType "pads_ami06" "PadGnd" "layout") nil (list xpointv ypointh+2*90) "R90")
(dbCreateInst (getEditRep) (dbOpenCellViewByType "pads_ami06" "PadIO"  "layout") nil (list xpointv ypointh+3*90) "R90")
(dbCreateInst (getEditRep) (dbOpenCellViewByType "pads_ami06" "PadIO"  "layout") nil (list xpointv ypointh+4*90) "R90")
(dbCreateInst (getEditRep) (dbOpenCellViewByType "pads_ami06" "PadIO"  "layout") nil (list xpointv ypointh+5*90) "R90")
(dbCreateInst (getEditRep) (dbOpenCellViewByType "pads_ami06" "PadIO"  "layout") nil (list xpointv ypointh+6*90) "R90")
(dbCreateInst (getEditRep) (dbOpenCellViewByType "pads_ami06" "PadIO"  "layout") nil (list xpointv ypointh+7*90) "R90")
(dbCreateInst (getEditRep) (dbOpenCellViewByType "pads_ami06" "PadIO"  "layout") nil (list xpointv ypointh+8*90) "R90")
(dbCreateInst (getEditRep) (dbOpenCellViewByType "pads_ami06" "PadIO"  "layout") nil (list xpointv ypointh+9*90) "R90")
(dbCreateInst (getEditRep) (dbOpenCellViewByType "pads_ami06" "PadOut"  "layout") nil (list xpointv ypointh+10*90) "R90")
(dbCreateInst (getEditRep) (dbOpenCellViewByType "pads_ami06" "PadOut"  "layout") nil (list xpointv ypointh+11*90) "R90")

(dbCreateInst (getEditRep) (dbOpenCellViewByType "pads_ami06" "PadOut" "layout") nil (list xpointv ypointh+no_pads*90) "R0")
(dbCreateInst (getEditRep) (dbOpenCellViewByType "pads_ami06" "PadIO"  "layout") nil (list xpointv+90 ypointh+no_pads*90) "R0")
(dbCreateInst (getEditRep) (dbOpenCellViewByType "pads_ami06" "PadVdd" "layout") nil (list xpointv+90*2 ypointh+no_pads*90) "R0")
(dbCreateInst (getEditRep) (dbOpenCellViewByType "pads_ami06" "PadIO"  "layout") nil (list xpointv+90*3 ypointh+no_pads*90) "R0")
(dbCreateInst (getEditRep) (dbOpenCellViewByType "pads_ami06" "PadIO"  "layout") nil (list xpointv+90*4 ypointh+no_pads*90) "R0")
(dbCreateInst (getEditRep) (dbOpenCellViewByType "pads_ami06" "PadIO"  "layout") nil (list xpointv+90*5 ypointh+no_pads*90) "R0")
(dbCreateInst (getEditRep) (dbOpenCellViewByType "pads_ami06" "PadIO"  "layout") nil (list xpointv+90*6 ypointh+no_pads*90) "R0")
(dbCreateInst (getEditRep) (dbOpenCellViewByType "pads_ami06" "PadIO"  "layout") nil (list xpointv+90*7 ypointh+no_pads*90) "R0")
(dbCreateInst (getEditRep) (dbOpenCellViewByType "pads_ami06" "PadIO"  "layout") nil (list xpointv+90*8 ypointh+no_pads*90) "R0")
(dbCreateInst (getEditRep) (dbOpenCellViewByType "pads_ami06" "PadIO"  "layout") nil (list xpointv+90*9 ypointh+no_pads*90) "R0")
(dbCreateInst (getEditRep) (dbOpenCellViewByType "pads_ami06" "PadOut"  "layout") nil (list xpointv+90*10 ypointh+no_pads*90) "R0")
(dbCreateInst (getEditRep) (dbOpenCellViewByType "pads_ami06" "PadOut"  "layout") nil (list xpointv+90*11 ypointh+no_pads*90) "R0")

(dbCreateInst (getEditRep) (dbOpenCellViewByType "pads_ami06" "PadOut" "layout") nil (list xpointv+no_pads*90 ypointv) "R270")
(dbCreateInst (getEditRep) (dbOpenCellViewByType "pads_ami06" "PadIO"  "layout") nil (list xpointv+no_pads*90 ypointv+90) "R270")
(dbCreateInst (getEditRep) (dbOpenCellViewByType "pads_ami06" "PadGnd" "layout") nil (list xpointv+no_pads*90 ypointv+2*90) "R270")
(dbCreateInst (getEditRep) (dbOpenCellViewByType "pads_ami06" "PadIO"  "layout") nil (list xpointv+no_pads*90 ypointv+3*90) "R270")
(dbCreateInst (getEditRep) (dbOpenCellViewByType "pads_ami06" "PadIO" "layout") nil (list xpointv+no_pads*90 ypointv+4*90) "R270")
(dbCreateInst (getEditRep) (dbOpenCellViewByType "pads_ami06" "PadIO"  "layout") nil (list xpointv+no_pads*90 ypointv+5*90) "R270")
(dbCreateInst (getEditRep) (dbOpenCellViewByType "pads_ami06" "PadIO" "layout") nil (list xpointv+no_pads*90 ypointv+6*90) "R270")
(dbCreateInst (getEditRep) (dbOpenCellViewByType "pads_ami06" "PadIO"  "layout") nil (list xpointv+no_pads*90 ypointv+7*90) "R270")
(dbCreateInst (getEditRep) (dbOpenCellViewByType "pads_ami06" "PadOut" "layout") nil (list xpointv+no_pads*90 ypointv+8*90) "R270")
(dbCreateInst (getEditRep) (dbOpenCellViewByType "pads_ami06" "PadOut"  "layout") nil (list xpointv+no_pads*90 ypointv+9*90) "R270")
(dbCreateInst (getEditRep) (dbOpenCellViewByType "pads_ami06" "PadOut" "layout") nil (list xpointv+no_pads*90 ypointv+10*90) "R270")
(dbCreateInst (getEditRep) (dbOpenCellViewByType "pads_ami06" "PadOut"  "layout") nil (list xpointv+no_pads*90 ypointv+11*90) "R270")

(dbCreateInst (getEditRep) (dbOpenCellViewByType "pads_ami06" "PadFC" "layout") nil (list xpointv-300 ypointh+no_pads*90) "R0")
(dbCreateInst (getEditRep) (dbOpenCellViewByType "pads_ami06" "PadFC" "layout") nil (list xpointv+no_pads*90 ypointh+no_pads*90+300) "R270")
(dbCreateInst (getEditRep) (dbOpenCellViewByType "pads_ami06" "PadFC" "layout") nil (list xpointv+no_pads*90+300 201) "R180")
(dbCreateInst (getEditRep) (dbOpenCellViewByType "pads_ami06" "PadFC" "layout") nil (list xpointv ypointh-300) "R90")
)
